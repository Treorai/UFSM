ADE simulation setup
Run mode: Single Run, Sweeps and Corners
Tests:
  concepcao_aulas_test_switch_x1_1: concepcao_aulas/test_switch_x1/schematic, simulator spectre
    Outputs: /V_in; /V_out; /ctrl
