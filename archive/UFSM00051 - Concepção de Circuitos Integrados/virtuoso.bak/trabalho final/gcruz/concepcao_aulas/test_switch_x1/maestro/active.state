ADE simulation setup
Test concepcao_aulas_test_inv_x1_1: concepcao_aulas/test_inv_x1/schematic, simulator spectre
  Models: /home/tools/design_kits/cadence/GPDK045/gpdk045_v_6_0/gpdk045/../models/spectre/gpdk045.scs[mc]
  Temperature: 27
  Analysis dc: sweep /V1.dc start=0 stop=1 step=300u (saves the operating point)
  Signals: /V_in, /V_out
Test concepcao_aulas_test_switch_x1_1: concepcao_aulas/test_switch_x1/schematic, simulator spectre
  Models: /home/tools/design_kits/cadence/GPDK045/gpdk045_v_6_0/gpdk045/../models/spectre/gpdk045.scs[mc]
  Temperature: 27
  Analysis tran: stop=5000n
  Signals: /ctrl, /V_in, /V_out
