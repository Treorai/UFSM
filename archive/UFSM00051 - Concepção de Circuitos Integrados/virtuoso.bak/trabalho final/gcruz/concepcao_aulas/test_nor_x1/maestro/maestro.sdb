ADE simulation setup
Run mode: Single Run, Sweeps and Corners
Tests:
  concepcao_aulas_test_nor_1: concepcao_aulas/test_nor_x1/schematic, simulator spectre
    Outputs: /A; /B; /S
