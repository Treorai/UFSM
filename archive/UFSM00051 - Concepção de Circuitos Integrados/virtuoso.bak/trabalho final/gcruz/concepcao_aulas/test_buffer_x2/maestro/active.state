ADE simulation setup
Test concepcao_aulas_test_buffer_x2_1: concepcao_aulas/test_buffer_x2/schematic, simulator spectre
  Models: /home/tools/design_kits/cadence/GPDK045/gpdk045_v_6_0/gpdk045/../models/spectre/gpdk045.scs[mc]
  Temperature: 27
  Analysis tran: stop=500n
  Signals: /A, /S
Run mode: Single Run, Sweeps and Corners
