ADE simulation setup
Run mode: Single Run, Sweeps and Corners
Tests:
  concepcao_aulas_test_buffer_x2_1: concepcao_aulas/test_buffer_x2/schematic, simulator spectre
    Outputs: /A; /S
