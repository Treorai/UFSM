ADE simulation setup
Run mode: Single Run, Sweeps and Corners
Tests:
  concepcao_aulas_test_inv_x1_1: concepcao_aulas/test_inv_x1/schematic, simulator spectre
    Outputs: /V_in; /V_out; /V0/PLUS; /test/NM0/D
