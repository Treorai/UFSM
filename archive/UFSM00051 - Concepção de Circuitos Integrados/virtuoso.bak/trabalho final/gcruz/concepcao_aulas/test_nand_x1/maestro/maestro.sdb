ADE simulation setup
Run mode: Single Run, Sweeps and Corners
Tests:
  concepcao_aulas_test_nand_x1_1: concepcao_aulas/test_nand_x1/schematic, simulator spectre
    Variables: vdc = 0
