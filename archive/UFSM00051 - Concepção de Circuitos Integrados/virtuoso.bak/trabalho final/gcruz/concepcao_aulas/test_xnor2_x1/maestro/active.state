ADE simulation setup
Test concepcao_aulas_test_xnor2_x1_1: concepcao_aulas/test_xnor2_x1/schematic, simulator spectre
  Models: /home/tools/design_kits/cadence/GPDK045/gpdk045_v_6_0/gpdk045/../models/spectre/gpdk045.scs[mc]
  Temperature: 27
  Analysis tran: stop=200n
  Signals: /Ain, /Bin, /AxnorB
Run mode: Single Run, Sweeps and Corners
