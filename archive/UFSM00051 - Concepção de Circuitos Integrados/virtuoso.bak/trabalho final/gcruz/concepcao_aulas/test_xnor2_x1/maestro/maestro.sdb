ADE simulation setup
Run mode: Single Run, Sweeps and Corners
Tests:
  concepcao_aulas_test_xnor2_x1_1: concepcao_aulas/test_xnor2_x1/schematic, simulator spectre
    Outputs: /Ain; /Bin; /AxnorB
