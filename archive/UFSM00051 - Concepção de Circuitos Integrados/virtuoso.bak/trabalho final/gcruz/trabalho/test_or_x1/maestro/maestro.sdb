ADE simulation setup
Run mode: Single Run, Sweeps and Corners
Tests:
  trabalho_test_or_x1_1: trabalho/test_or_x1/schematic, simulator spectre
    Outputs: /Va; /Vb; /A_or_B
