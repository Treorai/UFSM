ADE simulation setup
Test trabalho_test_or_x1_1: trabalho/test_or_x1/schematic, simulator spectre
  Models: /home/tools/design_kits/cadence/GPDK045/gpdk045_v_6_0/gpdk045/../models/spectre/gpdk045.scs[mc]
  Temperature: 27
  Analysis tran: stop=1000n
  Signals: /Va, /Vb, /A_or_B
Run mode: Single Run, Sweeps and Corners
