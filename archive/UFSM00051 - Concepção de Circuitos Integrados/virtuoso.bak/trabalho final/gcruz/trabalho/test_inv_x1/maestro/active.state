ADE simulation setup
Test trabalho_test_inv_x1_1: trabalho/test_inv_x1/schematic, simulator spectre
  Models: /home/tools/design_kits/cadence/GPDK045/gpdk045_v_6_0/gpdk045/../models/spectre/gpdk045.scs[mc]
  Temperature: 27
  Analysis tran: stop=1000n
  Signals: /net1, /net2
Run mode: Single Run, Sweeps and Corners
