ADE simulation setup
Run mode: Single Run, Sweeps and Corners
Tests:
  trabalho_test_inv_x1_1: trabalho/test_inv_x1/schematic, simulator spectre
    Outputs: /net1; /net2
