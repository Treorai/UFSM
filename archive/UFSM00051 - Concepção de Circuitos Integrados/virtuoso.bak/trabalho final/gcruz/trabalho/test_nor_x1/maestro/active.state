ADE simulation setup
Test concepcao_aulas_test_nor_1: concepcao_aulas/test_nor_x1/schematic, simulator spectre
  Models: /home/tools/design_kits/cadence/GPDK045/gpdk045_v_6_0/gpdk045/../models/spectre/gpdk045.scs[mc]
  Temperature: 27
  Analysis tran: stop=5u
  Signals: /A, /B, /S
