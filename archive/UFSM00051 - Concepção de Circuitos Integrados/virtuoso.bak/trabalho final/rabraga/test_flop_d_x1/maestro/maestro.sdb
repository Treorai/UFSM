ADE simulation setup
Run mode: Single Run, Sweeps and Corners
Tests:
  rabraga_test_flop_d_x1_1: rabraga/test_flop_d_x1/config, simulator spectre
    Outputs: /a; /b; /q; /qn; /q_ex; /qn_ex
