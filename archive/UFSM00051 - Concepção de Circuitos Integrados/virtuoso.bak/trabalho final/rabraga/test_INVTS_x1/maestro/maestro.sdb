ADE simulation setup
Run mode: Single Run, Sweeps and Corners
Tests:
  rabraga_test_INVTS_x1_1: rabraga/test_INVTS_x1/config, simulator spectre
    Outputs: /a; /b; /c; /c_ext
