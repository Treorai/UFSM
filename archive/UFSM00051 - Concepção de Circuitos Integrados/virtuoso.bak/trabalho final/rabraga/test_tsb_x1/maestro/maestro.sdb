ADE simulation setup
Run mode: Single Run, Sweeps and Corners
Tests:
  rabraga_test_tsb_x1_1: rabraga/test_tsb_x1/config, simulator spectre
    Outputs: /a; /b; /c; /c_ext
