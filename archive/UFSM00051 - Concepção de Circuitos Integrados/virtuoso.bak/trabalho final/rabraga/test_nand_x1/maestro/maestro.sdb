ADE simulation setup
Run mode: Single Run, Sweeps and Corners
Tests:
  rabraga_test_nand_x1_1: rabraga/test_nand_x1/config, simulator spectre
    Outputs: /c_ext
