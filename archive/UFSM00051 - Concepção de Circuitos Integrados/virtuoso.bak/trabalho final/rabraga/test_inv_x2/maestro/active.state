ADE simulation setup
Test rabraga_test_inv_x2_1: rabraga/test_inv_x2/config, simulator spectre
  Models: /home/tools/design_kits/cadence/GPDK045/gpdk045_v_6_0/gpdk045/../models/spectre/gpdk045.scs[mc]
  Temperature: 27
  Analysis dc: sweep /V1.dc start=0 stop=1 (saves the operating point)
  Analysis tran: stop=300n
  Signals: /a, /Vout, /Vout_ext
Run mode: Single Run, Sweeps and Corners
