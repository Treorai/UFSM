ADE simulation setup
Run mode: Single Run, Sweeps and Corners
Tests:
  rabraga_test_inv_x2_1: rabraga/test_inv_x2/config, simulator spectre
    Outputs: /a; /Vout; /Vout_ext
