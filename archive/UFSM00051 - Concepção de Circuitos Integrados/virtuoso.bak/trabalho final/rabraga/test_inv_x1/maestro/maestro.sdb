ADE simulation setup
Run mode: Single Run, Sweeps and Corners
Tests:
  rabraga_test_inv_x1_1: rabraga/test_inv_x1/config, simulator spectre
    Outputs: /C0/PLUS; /V1/PLUS; /net2; /net1; "/"; /; /vdd!; /V0/PLUS; /Vin; /Vout; /Vout_ext; /a
