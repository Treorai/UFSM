ADE simulation setup
Test rabraga_test_inv_x1_1: rabraga/test_switchtg_x1/config, simulator spectre
  Models: /home/tools/design_kits/cadence/GPDK045/gpdk045_v_6_0/gpdk045/../models/spectre/gpdk045.scs[mc]
  Temperature: 27
  Analysis dc: sweep /V2.dc start=0 stop=1
  Analysis tran: stop=300n
  Signals: /Vin, /Vout, /Ctrl, /Ctrl_
Run mode: Single Run, Sweeps and Corners
