ADE simulation setup
Run mode: Single Run, Sweeps and Corners
Tests:
  rabraga_test_inv_x1_1: rabraga/test_switchtg_x1/config, simulator spectre
    Outputs: /C0/PLUS; /V1/PLUS; /net2; /net1; "/"; /; /vdd!; /V0/PLUS; /I0/NM0/D; /Vin; /Vout; /Ctrl; /Ctrl_
