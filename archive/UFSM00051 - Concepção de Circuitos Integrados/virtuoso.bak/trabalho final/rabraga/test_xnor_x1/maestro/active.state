ADE simulation setup
Test rabraga_test_xnor_x1_1: rabraga/test_xnor_x1/config, simulator spectre
  Models: /home/tools/design_kits/cadence/GPDK045/gpdk045_v_6_0/gpdk045/../models/spectre/gpdk045.scs[mc]
  Temperature: 27
  Analysis tran: stop=300n
  Signals: /a, /b, /c, /c_ext
Run mode: Single Run, Sweeps and Corners
