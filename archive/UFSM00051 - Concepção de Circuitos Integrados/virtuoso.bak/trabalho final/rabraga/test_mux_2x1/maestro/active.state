ADE simulation setup
Test rabraga_test_mux_2x1_1: rabraga/test_mux_2x1/config, simulator spectre
  Models: /home/tools/design_kits/cadence/GPDK045/gpdk045_v_6_0/gpdk045/../models/spectre/gpdk045.scs[mc]
  Temperature: 27
  Analysis tran: stop=300n
  Signals: /a, /b, /sel, /c, /c_ext
Run mode: Single Run, Sweeps and Corners
