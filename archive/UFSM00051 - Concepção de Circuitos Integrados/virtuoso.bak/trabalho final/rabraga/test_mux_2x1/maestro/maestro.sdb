ADE simulation setup
Run mode: Single Run, Sweeps and Corners
Tests:
  rabraga_test_mux_2x1_1: rabraga/test_mux_2x1/config, simulator spectre
    Outputs: /a; /b; /c; /sel; /c_ext; /V3/PLUS
