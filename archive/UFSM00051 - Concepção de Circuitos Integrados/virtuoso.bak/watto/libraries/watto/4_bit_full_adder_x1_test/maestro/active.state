ADE simulation setup
Test watto_4_bit_full_adder_x1_test_1: watto/4_bit_full_adder_x1_test/schematic, simulator spectre
  Models: /home/tools/design_kits/cadence/GPDK045/gpdk045_v_6_0/gpdk045/../models/spectre/gpdk045.scs[mc]
  Variables: vcm = 0
  Temperature: 27
  Analysis tran: stop=51200n
  Analysis dc: sweep vcm start=0 stop=1
  Signals: /A0, /A1, /A2, /A3, /B0, /B1, /B2, /B3, /Cin, /S0, /S1, /S2, /S3, /Cout
