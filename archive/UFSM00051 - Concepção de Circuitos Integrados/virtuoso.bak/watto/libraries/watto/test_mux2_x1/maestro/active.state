ADE simulation setup
Test watto_test_mux2_x1_1: watto/test_mux2_x1/config, simulator spectre
  Models: /home/tools/design_kits/cadence/GPDK045/gpdk045_v_6_0/gpdk045/../models/spectre/gpdk045.scs[mc]
  Variables: vcm = 0
  Temperature: 27
  Analysis tran: stop=800n
  Analysis dc: sweep vcm start=0 stop=1
  Signals: /A as A, /B as B, /Sel as Sel, /S as S, /SEx as SEx
