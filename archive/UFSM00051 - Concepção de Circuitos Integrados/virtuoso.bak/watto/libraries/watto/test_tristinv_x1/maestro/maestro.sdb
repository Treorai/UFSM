ADE simulation setup
Run mode: Single Run, Sweeps and Corners
Tests:
  watto_test_tristinv_x1_1: watto/test_tristinv_x1/config, simulator spectre
    Variables: vcm = 0
    Outputs: en; Vin; "/S"; Vout; VoutEx
