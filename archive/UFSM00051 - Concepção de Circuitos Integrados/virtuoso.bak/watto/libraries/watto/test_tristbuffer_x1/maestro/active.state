ADE simulation setup
Test watto_test_tristbuffer_x1_1: watto/test_tristbuffer_x1/config, simulator spectre
  Models: /home/tools/design_kits/cadence/GPDK045/gpdk045_v_6_0/gpdk045/../models/spectre/gpdk045.scs[mc]
  Variables: vcm = 0
  Temperature: 27
  Analysis tran: stop=500n
  Analysis dc: sweep vcm start=0 stop=1
  Signals: /Vin as Vin, /en as en, /Vout as Vout, /VoutEx as VoutEx
Run mode: Single Run, Sweeps and Corners
