ADE simulation setup
Run mode: Single Run, Sweeps and Corners
Tests:
  watto_test_tristbuffer_x1_1: watto/test_tristbuffer_x1/config, simulator spectre
    Variables: vcm = 0
    Outputs: Vin; en; Vout; VoutEx
