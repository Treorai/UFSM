ADE simulation setup
Run mode: Single Run, Sweeps and Corners
Tests:
  watto_test_flipflopD_x1_1: watto/test_flipflopD_ms_x1/config, simulator spectre
    Variables: vcm = 0
    Outputs: D; clk; Q; Qbar; QEx; QbarEx
