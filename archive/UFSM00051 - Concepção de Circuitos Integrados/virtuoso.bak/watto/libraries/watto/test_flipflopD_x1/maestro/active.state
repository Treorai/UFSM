ADE simulation setup
Test watto_test_flipflopD_x1_1: watto/test_flipflopD_x1/schematic, simulator spectre
  Models: /home/tools/design_kits/cadence/GPDK045/gpdk045_v_6_0/gpdk045/../models/spectre/gpdk045.scs[mc]
  Variables: vcm = 0
  Temperature: 27
  Analysis dc: sweep vcm start=0 stop=1
  Analysis tran: stop=400n
  Signals: /Reset, /clk, /D, /Q, /QEx
Run mode: Single Run, Sweeps and Corners
