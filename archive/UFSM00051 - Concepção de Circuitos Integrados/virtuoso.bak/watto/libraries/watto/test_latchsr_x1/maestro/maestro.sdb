ADE simulation setup
Run mode: Single Run, Sweeps and Corners
Tests:
  watto_test_latchsr_x1_1: watto/test_latchsr_x1/config, simulator spectre
    Variables: vcm = 0
    Outputs: Set; Reset; Q; Qbar; QEx; QbarEx
