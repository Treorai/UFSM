ADE simulation setup
Run mode: Single Run, Sweeps and Corners
Tests:
  watto_4_bit_register_x1_test_1: watto/4_bit_register_x1_test/schematic, simulator spectre
    Variables: vcm = 0; s = 0
    Outputs: in0; in1; in2; in3; enable; clk; out0; out1; out2; out3; Res
