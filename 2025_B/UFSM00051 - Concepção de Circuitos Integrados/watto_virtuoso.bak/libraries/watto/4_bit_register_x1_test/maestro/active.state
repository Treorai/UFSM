ADE simulation setup
Test watto_4_bit_register_x1_test_1: watto/4_bit_register_x1_test/schematic, simulator spectre
  Models: /home/tools/design_kits/cadence/GPDK045/gpdk045_v_6_0/gpdk045/../models/spectre/gpdk045.scs[mc]
  Variables: s = 0; vcm = 0
  Temperature: 27
  Analysis tran: stop=4u
  Signals: /B0 as in0, /B1 as in1, /B2 as in2, /B3 as in3, /Enable as enable, /clk as clk, /S0 as out0, /S1 as out1, /S2 as out2, /S3 as out3, /Reset as Res
Run mode: Single Run, Sweeps and Corners
