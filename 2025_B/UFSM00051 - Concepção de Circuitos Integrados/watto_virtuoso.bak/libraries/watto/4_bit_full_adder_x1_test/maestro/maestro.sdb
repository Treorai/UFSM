ADE simulation setup
Run mode: Single Run, Sweeps and Corners
Tests:
  watto_4_bit_full_adder_x1_test_1: watto/4_bit_full_adder_x1_test/schematic, simulator spectre
    Variables: vcm = 0
    Outputs: /A3; /A1; /A2; /A0; /B1; "/B0"; /B0; /B2; /B3; "/Cin"; /Cin; /S0; /S1; /S2; /S3; /Cout
