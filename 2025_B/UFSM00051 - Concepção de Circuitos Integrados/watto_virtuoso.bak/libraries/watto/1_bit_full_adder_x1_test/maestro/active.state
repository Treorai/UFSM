ADE simulation setup
Test watto_1_bit_full_adder_x1_test_1: watto/1_bit_full_adder_x1_test/schematic, simulator spectre
  Models: /home/tools/design_kits/cadence/GPDK045/gpdk045_v_6_0/gpdk045/../models/spectre/gpdk045.scs[mc]
  Variables: vcm = 0
  Temperature: 27
  Analysis tran: stop=1200n
  Analysis dc: sweep /V5.dc start=0 stop=1
  Signals: /A, /B, /Cin, /S, /Cout
Run mode: Single Run, Sweeps and Corners
