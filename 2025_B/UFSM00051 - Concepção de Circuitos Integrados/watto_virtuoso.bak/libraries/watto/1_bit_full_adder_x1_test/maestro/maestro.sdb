ADE simulation setup
Run mode: Single Run, Sweeps and Corners
Tests:
  watto_1_bit_full_adder_x1_test_1: watto/1_bit_full_adder_x1_test/schematic, simulator spectre
    Variables: vcm = 0
    Outputs: /A; /B; /Cin; /S; /Cout
