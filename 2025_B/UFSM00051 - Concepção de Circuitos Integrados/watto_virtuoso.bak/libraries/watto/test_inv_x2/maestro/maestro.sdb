ADE simulation setup
Run mode: Single Run, Sweeps and Corners
Tests:
  watto_test_inv_x2_1: watto/test_inv_x2/config, simulator spectre
    Variables: vcm = 0
    Outputs: Vin; Vout; VoutEx
