ADE simulation setup
Run mode: Single Run, Sweeps and Corners
Tests:
  watto_test_switch_x1_1: watto/test_switch_x1/config, simulator spectre
    Variables: vcm = 0
    Outputs: Vin; ctrl; Vout; VoutEx
