ADE simulation setup
Run mode: Single Run, Sweeps and Corners
Tests:
  watto_test_buffer_x2_1: watto/test_buffer_x2/schematic, simulator spectre
    Variables: vcm = 0
    Outputs: Vin; Vout; VoutEx
