ADE simulation setup
Test watto_test_flipflopD_x1_1: watto/test_flipflopD_ms_x1/config, simulator spectre
  Models: /home/tools/design_kits/cadence/GPDK045/gpdk045_v_6_0/gpdk045/../models/spectre/gpdk045.scs[mc]
  Variables: vcm = 0
  Temperature: 27
  Analysis tran: stop=800n
  Analysis dc: sweep vcm start=0 stop=1
  Signals: /D as D, /clk as clk, /Q as Q, /Qbar as Qbar, /QEx as QEx, /QbarEx as QbarEx
