ADE simulation setup
Test watto_test_tristinv_x1_1: watto/test_tristinv_x1/config, simulator spectre
  Models: /home/tools/design_kits/cadence/GPDK045/gpdk045_v_6_0/gpdk045/../models/spectre/gpdk045.scs[mc]
  Variables: vcm = 0
  Temperature: 27
  Analysis tran: stop=400n
  Analysis dc: sweep vcm start=0 stop=1
  Signals: /en as en, /Vin as Vin, /S as Vout, /SEx as VoutEx
