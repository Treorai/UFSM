ADE simulation setup
Run mode: Single Run, Sweeps and Corners
Tests:
  watto_test_mux2_x1_1: watto/test_mux2_x1/config, simulator spectre
    Variables: vcm = 0
    Outputs: A; B; Sel; S; SEx
