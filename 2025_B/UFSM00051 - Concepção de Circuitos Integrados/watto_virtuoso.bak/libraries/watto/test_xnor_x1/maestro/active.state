ADE simulation setup
Test watto_test_xnor_x1_1: watto/test_xnor_x1/schematic, simulator spectre
  Models: /home/tools/design_kits/cadence/GPDK045/gpdk045_v_6_0/gpdk045/../models/spectre/gpdk045.scs[mc]
  Variables: vcm = 0
  Temperature: 27
  Analysis tran: stop=300n
  Analysis dc: sweep vcm start=0 stop=1
  Signals: /A as a, /B as b, /S as s, /SEx as sEx
Run mode: Single Run, Sweeps and Corners
