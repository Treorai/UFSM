ADE simulation setup
Run mode: Single Run, Sweeps and Corners
Tests:
  watto_test_xnor_x1_1: watto/test_xnor_x1/config, simulator spectre
    Variables: vcm = 0
    Outputs: a; b; s; sEx
