ADE simulation setup
Run mode: Single Run, Sweeps and Corners
Tests:
  watto_test_inv_x1_1: watto/test_inv_x1/config, simulator spectre
    Outputs: vout_I3; vout_I0
