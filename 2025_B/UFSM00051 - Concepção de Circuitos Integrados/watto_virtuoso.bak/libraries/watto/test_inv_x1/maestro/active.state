ADE simulation setup
Test watto_test_inv_x1_1: watto/test_inv_x1/config, simulator spectre
  Models: /home/tools/design_kits/cadence/GPDK045/gpdk045_v_6_0/gpdk045/../models/spectre/gpdk045.scs[mc]
  Temperature: 27
  Analysis tran: stop=500n
  Analysis dc: sweep /V1.dc start=0 stop=1 (saves the operating point)
  Signals: /Vin, /Vout_I0, /Vout_I3
Run mode: Single Run, Sweeps and Corners
