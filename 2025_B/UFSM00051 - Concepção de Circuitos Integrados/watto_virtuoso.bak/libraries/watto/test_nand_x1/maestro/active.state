ADE simulation setup
Test watto_test_inv_x1_1: watto/test_inv_x1/schematic, simulator spectre
  Models: /home/tools/design_kits/cadence/GPDK045/gpdk045_v_6_0/gpdk045/../models/spectre/gpdk045.scs[mc]
  Temperature: 27
  Analysis tran: stop=500n
  Analysis dc: sweep /V1.dc start=0 stop=1 (saves the operating point)
  Signals: /net1 as vin, /net2 as vout
Test watto_test_nand_x1_1: watto/test_nand_x1/config, simulator spectre
  Models: /home/tools/design_kits/cadence/GPDK045/gpdk045_v_6_0/gpdk045/../models/spectre/gpdk045.scs[mc]
  Variables: vcm = 0
  Temperature: 27
  Analysis tran: stop=300n
  Analysis dc: sweep vcm start=0 stop=1 (saves the operating point)
  Signals: /A as a, /B as b, /S as s, /SEx as sEx
