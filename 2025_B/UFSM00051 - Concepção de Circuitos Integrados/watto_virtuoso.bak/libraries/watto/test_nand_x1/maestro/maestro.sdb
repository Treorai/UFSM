ADE simulation setup
Run mode: Single Run, Sweeps and Corners
Tests:
  watto_test_nand_x1_1: watto/test_nand_x1/config, simulator spectre
    Variables: vcm = 0
    Outputs: a; b; s; sEx
